* Address-pin cycle with a series R and L on each drive line and on the sense string.
* Defaults are 1 uohm and 1 pH, the zero case (a literal 0 H is not a legal inductor).
* Same weave and Sim.Pins map as array2x2_tb.cir.
*
* One CCS for the X lines, one for the Y lines, one for inhibit, each 400 mA.
* Only one line on an axis is driven at a time, so that axis sink is the
* full half-select. All four cores start at m=-1.
*
* X00  X0/Y0  2 write 1, 8 read 1, 14 write-back 1, 20 clear, 26 write 0, 32 read 0, 38 write-back 0
* X01  X1/Y0  44 write 1, 50 read 1, 56 write-back 1, 62 clear, 68 write 0, 74 read 0, 80 write-back 0
* X10  X0/Y1  86 write 1, 92 read 1, 98 write-back 1, 104 clear, 110 write 0, 116 read 0, 122 write-back 0
* X11  X1/Y1  128 write 1, 134 read 1, 140 write-back 1, 146 clear, 152 write 0, 158 read 0, 164 write-back 0
*
* 1 us edges, 2 us flat, 1 us fall. Read sinks the A end (B->A).
* Write sinks the B end. Inhibit sources YA65 and sinks YB66.
* VDRIVE = 12 V is testbench headroom, not a frozen rail.
*
* Positive probe current is A->B. Batch: ngspice -b array2x2_matrix_tb.cir
* Prints RESULT PASS or RESULT FAIL.

.include coremem.cir
.include ccs.cir
.include drive.cir
.include inhibit.cir
.include sense.cir
.include decode.cir

.param vdrive=12
* Plane wire impedance. Docs record no numeric L or DCR; these defaults keep the pass.
.param rline=1u
.param lline=1p
.param rsense=1u
.param lsense=1p

Vdrive vdrv 0 DC {vdrive}
Viccsx ccs_x ccs_xin 0
Viccsy ccs_y ccs_yin 0
Viccsi ccs_i ccs_iin 0
Xccs_x ccs_xin ccs ic_half=0.4
Xccs_y ccs_yin ccs ic_half=0.4
Xccs_i ccs_iin ccs ic_half=0.4
Rx ccs_x 0 10Meg
Ry ccs_y 0 10Meg
Ri ccs_i 0 10Meg

Rxa0 xa0d 0 10Meg
Rxa1 xa1d 0 10Meg
Rya0 ya0d 0 10Meg
Rya1 ya1d 0 10Meg
Rfold FOLD 0 10k

* One R and one L on each drive line, and one pair on the sense string.
Rx0 XA0 x0r {rline}
Lx0 x0r x0w {lline}
Rx1 XA1 x1r {rline}
Lx1 x1r x1w {lline}
Ry0 YB0 y0r {rline}
Ly0 y0r y0w {lline}
Ry1 YB1 y1r {rline}
Ly1 y1r y1w {lline}
Rsn YA65 snr {rsense}
Lsn snr snw {lsense}
* X1 X2 Y1 Y2 S1 S2
X00 x0w nX0 nY0 y0w FOLD nSA mce m0=-1
X10 nX0 XB0 nY1 y1w nSB FOLD mce m0=-1
X01 x1w nX1 YA0 nY0 YB66 nSB mce m0=-1
X11 nX1 XB1 YA1 nY1 nSA snw mce m0=-1

Bdiff DIFF 0 V = V(YA65)-V(YB66)

Vixa0 xa0d XA0 0
Vixa1 xa1d XA1 0
Viya0 ya0d YA0 0
Viya1 ya1d YA1 0
Vinh inhd YA65 0
Bpxa0 PXA0 0 V = I(Vixa0)
Bpxa1 PXA1 0 V = I(Vixa1)
Bpya0 PYA0 0 V = I(Viya0)
Bpya1 PYA1 0 V = I(Viya1)
Bpinh PINH 0 V = I(Vinh)
Bpiccsx PICCSX 0 V = I(Viccsx)
Bpiccsy PICCSY 0 V = I(Viccsy)
Bpiccsi PICCSI 0 V = I(Viccsi)

* Ramps from a few hundred ohms down to 1 ohm across the 1 us edge.
.subckt drvsw a b ctl
Bsw a b I=(v(ctl)>0.02 ? v(a,b)/(1+400*(1-min(v(ctl),1))) : 0)
.ends

* 200 ns on each gate. A raw PWL corner into both lines of a shared HS
* drops the trap step to the floor.
.subckt glag in out
R1 in out 2k
C1 out 0 100p
.ends
Xlx0r g_x0r gx0r glag
Xlx1r g_x1r gx1r glag
Xlx0w g_x0w gx0w glag
Xlx1w g_x1w gx1w glag
Xly0r g_y0r gy0r glag
Xly1r g_y1r gy1r glag
Xly0w g_y0w gy0w glag
Xly1w g_y1w gy1w glag

* Matrix: group-0 HS feeds both lines; LS group selects the line.
* FWD/READ sources B and sinks A. REV/WRITE sources A and sinks B.
* Group-1 HS has no plane diode. Inhibit stays the ideal switch.
Bhsxr hsxr 0 V=max(v(gx0r),v(gx1r))
Bhsxw hsxw 0 V=max(v(gx0w),v(gx1w))
Bhsyr hsyr 0 V=max(v(gy0r),v(gy1r))
Bhsyw hsyw 0 V=max(v(gy0w),v(gy1w))
Vg_off g_off 0 DC 0
Vpxhs1 vdrv pxhs1 0
Vpxhs1w vdrv pxhs1w 0
Vpyhs1 vdrv pyhs1 0
Vpyhs1w vdrv pyhs1w 0
Xxf_hs0 vdrv XB0 hsxr drvleg
Xxf_hs0b vdrv XB1 hsxr drvleg
Xxf_ls0 xa0d ccs_x gx0r drvleg
Xxf_ls1 xa1d ccs_x gx1r drvleg
Xxf_hs1 pxhs1 xhs1n g_off drvleg
Rxhs1 xhs1n 0 10Meg
Xxw_hs0 vdrv xa0d hsxw drvleg
Xxw_hs0b vdrv xa1d hsxw drvleg
Xxw_ls0 XB0 ccs_x gx0w drvleg
Xxw_ls1 XB1 ccs_x gx1w drvleg
Xxw_hs1 pxhs1w xhs1nw g_off drvleg
Rxhs1w xhs1nw 0 10Meg
Xyf_hs0 vdrv YB0 hsyr drvleg
Xyf_hs0b vdrv YB1 hsyr drvleg
Xyf_ls0 ya0d ccs_y gy0r drvleg
Xyf_ls1 ya1d ccs_y gy1r drvleg
Xyf_hs1 pyhs1 yhs1n g_off drvleg
Ryhs1 yhs1n 0 10Meg
Xyw_hs0 vdrv ya0d hsyw drvleg
Xyw_hs0b vdrv ya1d hsyw drvleg
Xyw_ls0 YB0 ccs_y gy0w drvleg
Xyw_ls1 YB1 ccs_y gy1w drvleg
Xyw_hs1 pyhs1w yhs1nw g_off drvleg
Ryhs1w yhs1nw 0 10Meg
* Short strobe once the flip plateau has charged the sense probe.
* A wide strobe tracks back down when the plateau ends.
Bstrobe strobe 0 V=3.3*(
+ +exp(-((time-9.95e-6)/1e-7)**2)
+ +exp(-((time-21.95e-6)/1e-7)**2)
+ +exp(-((time-33.95e-6)/1e-7)**2)
+ +exp(-((time-51.95e-6)/1e-7)**2)
+ +exp(-((time-63.95e-6)/1e-7)**2)
+ +exp(-((time-75.95e-6)/1e-7)**2)
+ +exp(-((time-93.95e-6)/1e-7)**2)
+ +exp(-((time-106.0e-6)/1e-7)**2)
+ +exp(-((time-118.0e-6)/1e-7)**2)
+ +exp(-((time-136.0e-6)/1e-7)**2)
+ +exp(-((time-148.0e-6)/1e-7)**2)
+ +exp(-((time-160.0e-6)/1e-7)**2))
Xsense YA65 YB66 strobe dout sense
Xinh vdrv inhd YB66 ccs_i g_inh inhibit
* Sheet pin INH_EN_n is active-low. g_inh is the level after the drivers.
Binh_n inh_en_n 0 V=3.3*(1-v(g_inh))

* Address and enables. Line 0 is NH=0,NL=0. Line 1 is NH=0,NL=1.
Vaxh0 axh0 0 DC 0
Vaxh1 axh1 0 DC 0
Vaxh2 axh2 0 DC 0
Vaxl1 axl1 0 DC 0
Vaxl2 axl2 0 DC 0
Vayh0 ayh0 0 DC 0
Vayh1 ayh1 0 DC 0
Vayh2 ayh2 0 DC 0
Vayl1 ayl1 0 DC 0
Vayl2 ayl2 0 DC 0
* Decode CTRL pulls: DEC_EN down, FWD_EN_n and REV_EN_n up, 10 kohm.
* The sources override the pulls until 171.5 us, then the series path opens.
Vlogic vlogic 0 DC 3.3
Rdec dec_en 0 10k
Rfwd fwd_en_n vlogic 10k
Rrev rev_en_n vlogic 10k
Bopen en_open 0 V=0.5*(1+tanh((time-171.5e-6)/2e-7))
Bdec dec_src dec_en I=v(dec_src,dec_en)/(1+1e8*v(en_open))
Bfwd fwd_src fwd_en_n I=v(fwd_src,fwd_en_n)/(1+1e8*v(en_open))
Brev rev_src rev_en_n I=v(rev_src,rev_en_n)/(1+1e8*v(en_open))
Vdec dec_src 0 DC 3.3
Vaxl0 axl0 0 PWL(
+ 0 0
+ 43.5u 0 43.7u 3.3
+ 84.5u 3.3 84.7u 0
+ 127.5u 0 127.7u 3.3
+ 168.5u 3.3 168.7u 0)
Vayl0 ayl0 0 PWL(
+ 0 0
+ 85.5u 0 85.7u 3.3
+ 168.5u 3.3 168.7u 0)
Vfwd_en_n fwd_src 0 PWL(
+ 0 3.3
+ 8u 3.3 9u 0 11u 0 12u 3.3
+ 20u 3.3 21u 0 23u 0 24u 3.3
+ 32u 3.3 33u 0 35u 0 36u 3.3
+ 50u 3.3 51u 0 53u 0 54u 3.3
+ 62u 3.3 63u 0 65u 0 66u 3.3
+ 74u 3.3 75u 0 77u 0 78u 3.3
+ 92u 3.3 93u 0 95u 0 96u 3.3
+ 104u 3.3 105u 0 107u 0 108u 3.3
+ 116u 3.3 117u 0 119u 0 120u 3.3
+ 134u 3.3 135u 0 137u 0 138u 3.3
+ 146u 3.3 147u 0 149u 0 150u 3.3
+ 158u 3.3 159u 0 161u 0 162u 3.3
)
Vrev_en_n rev_src 0 PWL(
+ 0 3.3
+ 2u 3.3 3u 0 5u 0 6u 3.3
+ 14u 3.3 15u 0 17u 0 18u 3.3
+ 26u 3.3 27u 0 29u 0 30u 3.3
+ 38u 3.3 39u 0 41u 0 42u 3.3
+ 44u 3.3 45u 0 47u 0 48u 3.3
+ 56u 3.3 57u 0 59u 0 60u 3.3
+ 68u 3.3 69u 0 71u 0 72u 3.3
+ 80u 3.3 81u 0 83u 0 84u 3.3
+ 86u 3.3 87u 0 89u 0 90u 3.3
+ 98u 3.3 99u 0 101u 0 102u 3.3
+ 110u 3.3 111u 0 113u 0 114u 3.3
+ 122u 3.3 123u 0 125u 0 126u 3.3
+ 128u 3.3 129u 0 131u 0 132u 3.3
+ 140u 3.3 141u 0 143u 0 144u 3.3
+ 152u 3.3 153u 0 155u 0 156u 3.3
+ 164u 3.3 165u 0 167u 0 168u 3.3
)
Xdec_xf axh0 axh1 axh2 axl0 axl1 axl2 fwd_en_n dec_en
+ xhs0n xhs1n xhs2n xhs3n xhs4n xhs5n xhs6n xhs7n
+ xls0 xls1 xls2 xls3 xls4 xls5 xls6 xls7 decode
Xdec_xr axh0 axh1 axh2 axl0 axl1 axl2 rev_en_n dec_en
+ xhs0rn xhs1rn xhs2rn xhs3rn xhs4rn xhs5rn xhs6rn xhs7rn
+ xls0r xls1r xls2r xls3r xls4r xls5r xls6r xls7r decode
Xdec_yf ayh0 ayh1 ayh2 ayl0 ayl1 ayl2 fwd_en_n dec_en
+ yhs0n yhs1n yhs2n yhs3n yhs4n yhs5n yhs6n yhs7n
+ yls0 yls1 yls2 yls3 yls4 yls5 yls6 yls7 decode
Xdec_yr ayh0 ayh1 ayh2 ayl0 ayl1 ayl2 rev_en_n dec_en
+ yhs0rn yhs1rn yhs2rn yhs3rn yhs4rn yhs5rn yhs6rn yhs7rn
+ yls0r yls1r yls2r yls3r yls4r yls5r yls6r yls7r decode
* HS is active-low, LS active-high. The product is the gate command.
Bg_x0r g_x0r 0 V=(3.3-v(xhs0n))/3.3*v(xls0)/3.3
Bg_x1r g_x1r 0 V=(3.3-v(xhs0n))/3.3*v(xls1)/3.3
Bg_x0w g_x0w 0 V=(3.3-v(xhs0rn))/3.3*v(xls0r)/3.3
Bg_x1w g_x1w 0 V=(3.3-v(xhs0rn))/3.3*v(xls1r)/3.3
Bg_y0r g_y0r 0 V=(3.3-v(yhs0n))/3.3*v(yls0)/3.3
Bg_y1r g_y1r 0 V=(3.3-v(yhs0n))/3.3*v(yls1)/3.3
Bg_y0w g_y0w 0 V=(3.3-v(yhs0rn))/3.3*v(yls0r)/3.3
Bg_y1w g_y1w 0 V=(3.3-v(yhs0rn))/3.3*v(yls1r)/3.3
Vg_inh g_inh 0 PWL(
+ 0 0
+ 26u 0 27u 1 29u 1 30.5u 0
+ 38u 0 39u 1 41u 1 42.5u 0
+ 68u 0 69u 1 71u 1 72.5u 0
+ 80u 0 81u 1 83u 1 84.5u 0
+ 110u 0 111u 1 113u 1 114.5u 0
+ 122u 0 123u 1 125u 1 126.5u 0
+ 152u 0 153u 1 155u 1 156.5u 0
+ 164u 0 165u 1 167u 1 168.5u 0)

* Trap steps through the inhibited write. Gear collapses the timestep
* while every core sits on the remanence rail.
.options reltol=1e-3 method=trap cshunt=1p
.tran 20n 178u uic

.control
set nobreak
set noaskquit
run
meas tran i_unsel_x AVG i(Vixa1) FROM=10.2u TO=10.8u
meas tran i_unsel_y AVG i(Viya1) FROM=10.2u TO=10.8u
meas tran i_unsel_x0 AVG i(Vixa0) FROM=52.2u TO=52.8u
meas tran i_g1 AVG i(Vpxhs1) FROM=10.2u TO=10.8u

* State 0.5 us after each pulse. Sense plateau is after the rise.
meas tran m_x00_x00_w1 FIND v(x00.xcore.m) AT=7.3u
meas tran m_x01_x00_w1 FIND v(x01.xcore.m) AT=7.3u
meas tran m_x10_x00_w1 FIND v(x10.xcore.m) AT=7.3u
meas tran m_x11_x00_w1 FIND v(x11.xcore.m) AT=7.3u
meas tran smax_x00_w1 MAX v(diff) FROM=3.15u TO=5u
meas tran smin_x00_w1 MIN v(diff) FROM=3.15u TO=5u
meas tran ix_x00_w1 AVG i(Vixa0) FROM=4.2u TO=4.8u
meas tran iy_x00_w1 AVG i(Viya0) FROM=4.2u TO=4.8u
meas tran m_x00_x00_r1 FIND v(x00.xcore.m) AT=13.3u
meas tran m_x01_x00_r1 FIND v(x01.xcore.m) AT=13.3u
meas tran m_x10_x00_r1 FIND v(x10.xcore.m) AT=13.3u
meas tran m_x11_x00_r1 FIND v(x11.xcore.m) AT=13.3u
meas tran smax_x00_r1 MAX v(diff) FROM=9.15u TO=11u
meas tran smin_x00_r1 MIN v(diff) FROM=9.15u TO=11u
meas tran ix_x00_r1 AVG i(Vixa0) FROM=10.2u TO=10.8u
meas tran iy_x00_r1 AVG i(Viya0) FROM=10.2u TO=10.8u
meas tran m_x00_x00_b1 FIND v(x00.xcore.m) AT=19.3u
meas tran m_x01_x00_b1 FIND v(x01.xcore.m) AT=19.3u
meas tran m_x10_x00_b1 FIND v(x10.xcore.m) AT=19.3u
meas tran m_x11_x00_b1 FIND v(x11.xcore.m) AT=19.3u
meas tran smax_x00_b1 MAX v(diff) FROM=15.15u TO=17u
meas tran smin_x00_b1 MIN v(diff) FROM=15.15u TO=17u
meas tran ix_x00_b1 AVG i(Vixa0) FROM=16.2u TO=16.8u
meas tran iy_x00_b1 AVG i(Viya0) FROM=16.2u TO=16.8u
meas tran m_x00_x00_clr FIND v(x00.xcore.m) AT=25.3u
meas tran m_x01_x00_clr FIND v(x01.xcore.m) AT=25.3u
meas tran m_x10_x00_clr FIND v(x10.xcore.m) AT=25.3u
meas tran m_x11_x00_clr FIND v(x11.xcore.m) AT=25.3u
meas tran smax_x00_clr MAX v(diff) FROM=21.15u TO=23u
meas tran smin_x00_clr MIN v(diff) FROM=21.15u TO=23u
meas tran ix_x00_clr AVG i(Vixa0) FROM=22.2u TO=22.8u
meas tran iy_x00_clr AVG i(Viya0) FROM=22.2u TO=22.8u
meas tran m_x00_x00_w0 FIND v(x00.xcore.m) AT=31.3u
meas tran m_x01_x00_w0 FIND v(x01.xcore.m) AT=31.3u
meas tran m_x10_x00_w0 FIND v(x10.xcore.m) AT=31.3u
meas tran m_x11_x00_w0 FIND v(x11.xcore.m) AT=31.3u
meas tran smax_x00_w0 MAX v(diff) FROM=27.15u TO=29u
meas tran smin_x00_w0 MIN v(diff) FROM=27.15u TO=29u
meas tran ix_x00_w0 AVG i(Vixa0) FROM=28.2u TO=28.8u
meas tran iy_x00_w0 AVG i(Viya0) FROM=28.2u TO=28.8u
meas tran ii_x00_w0 AVG i(Vinh) FROM=28.2u TO=28.8u
meas tran m_x00_x00_r0 FIND v(x00.xcore.m) AT=37.3u
meas tran m_x01_x00_r0 FIND v(x01.xcore.m) AT=37.3u
meas tran m_x10_x00_r0 FIND v(x10.xcore.m) AT=37.3u
meas tran m_x11_x00_r0 FIND v(x11.xcore.m) AT=37.3u
meas tran smax_x00_r0 MAX v(diff) FROM=33.15u TO=35u
meas tran smin_x00_r0 MIN v(diff) FROM=33.15u TO=35u
meas tran ix_x00_r0 AVG i(Vixa0) FROM=34.2u TO=34.8u
meas tran iy_x00_r0 AVG i(Viya0) FROM=34.2u TO=34.8u
meas tran m_x00_x00_b0 FIND v(x00.xcore.m) AT=43.3u
meas tran m_x01_x00_b0 FIND v(x01.xcore.m) AT=43.3u
meas tran m_x10_x00_b0 FIND v(x10.xcore.m) AT=43.3u
meas tran m_x11_x00_b0 FIND v(x11.xcore.m) AT=43.3u
meas tran smax_x00_b0 MAX v(diff) FROM=39.15u TO=41u
meas tran smin_x00_b0 MIN v(diff) FROM=39.15u TO=41u
meas tran ix_x00_b0 AVG i(Vixa0) FROM=40.2u TO=40.8u
meas tran iy_x00_b0 AVG i(Viya0) FROM=40.2u TO=40.8u
meas tran ii_x00_b0 AVG i(Vinh) FROM=40.2u TO=40.8u
meas tran m_x00_x01_w1 FIND v(x00.xcore.m) AT=49.3u
meas tran m_x01_x01_w1 FIND v(x01.xcore.m) AT=49.3u
meas tran m_x10_x01_w1 FIND v(x10.xcore.m) AT=49.3u
meas tran m_x11_x01_w1 FIND v(x11.xcore.m) AT=49.3u
meas tran smax_x01_w1 MAX v(diff) FROM=45.15u TO=47u
meas tran smin_x01_w1 MIN v(diff) FROM=45.15u TO=47u
meas tran ix_x01_w1 AVG i(Vixa1) FROM=46.2u TO=46.8u
meas tran iy_x01_w1 AVG i(Viya0) FROM=46.2u TO=46.8u
meas tran m_x00_x01_r1 FIND v(x00.xcore.m) AT=55.3u
meas tran m_x01_x01_r1 FIND v(x01.xcore.m) AT=55.3u
meas tran m_x10_x01_r1 FIND v(x10.xcore.m) AT=55.3u
meas tran m_x11_x01_r1 FIND v(x11.xcore.m) AT=55.3u
meas tran smax_x01_r1 MAX v(diff) FROM=51.15u TO=53u
meas tran smin_x01_r1 MIN v(diff) FROM=51.15u TO=53u
meas tran ix_x01_r1 AVG i(Vixa1) FROM=52.2u TO=52.8u
meas tran iy_x01_r1 AVG i(Viya0) FROM=52.2u TO=52.8u
meas tran m_x00_x01_b1 FIND v(x00.xcore.m) AT=61.3u
meas tran m_x01_x01_b1 FIND v(x01.xcore.m) AT=61.3u
meas tran m_x10_x01_b1 FIND v(x10.xcore.m) AT=61.3u
meas tran m_x11_x01_b1 FIND v(x11.xcore.m) AT=61.3u
meas tran smax_x01_b1 MAX v(diff) FROM=57.15u TO=59u
meas tran smin_x01_b1 MIN v(diff) FROM=57.15u TO=59u
meas tran ix_x01_b1 AVG i(Vixa1) FROM=58.2u TO=58.8u
meas tran iy_x01_b1 AVG i(Viya0) FROM=58.2u TO=58.8u
meas tran m_x00_x01_clr FIND v(x00.xcore.m) AT=67.3u
meas tran m_x01_x01_clr FIND v(x01.xcore.m) AT=67.3u
meas tran m_x10_x01_clr FIND v(x10.xcore.m) AT=67.3u
meas tran m_x11_x01_clr FIND v(x11.xcore.m) AT=67.3u
meas tran smax_x01_clr MAX v(diff) FROM=63.15u TO=65u
meas tran smin_x01_clr MIN v(diff) FROM=63.15u TO=65u
meas tran ix_x01_clr AVG i(Vixa1) FROM=64.2u TO=64.8u
meas tran iy_x01_clr AVG i(Viya0) FROM=64.2u TO=64.8u
meas tran m_x00_x01_w0 FIND v(x00.xcore.m) AT=73.3u
meas tran m_x01_x01_w0 FIND v(x01.xcore.m) AT=73.3u
meas tran m_x10_x01_w0 FIND v(x10.xcore.m) AT=73.3u
meas tran m_x11_x01_w0 FIND v(x11.xcore.m) AT=73.3u
meas tran smax_x01_w0 MAX v(diff) FROM=69.15u TO=71u
meas tran smin_x01_w0 MIN v(diff) FROM=69.15u TO=71u
meas tran ix_x01_w0 AVG i(Vixa1) FROM=70.2u TO=70.8u
meas tran iy_x01_w0 AVG i(Viya0) FROM=70.2u TO=70.8u
meas tran ii_x01_w0 AVG i(Vinh) FROM=70.2u TO=70.8u
meas tran m_x00_x01_r0 FIND v(x00.xcore.m) AT=79.3u
meas tran m_x01_x01_r0 FIND v(x01.xcore.m) AT=79.3u
meas tran m_x10_x01_r0 FIND v(x10.xcore.m) AT=79.3u
meas tran m_x11_x01_r0 FIND v(x11.xcore.m) AT=79.3u
meas tran smax_x01_r0 MAX v(diff) FROM=75.15u TO=77u
meas tran smin_x01_r0 MIN v(diff) FROM=75.15u TO=77u
meas tran ix_x01_r0 AVG i(Vixa1) FROM=76.2u TO=76.8u
meas tran iy_x01_r0 AVG i(Viya0) FROM=76.2u TO=76.8u
meas tran m_x00_x01_b0 FIND v(x00.xcore.m) AT=85.3u
meas tran m_x01_x01_b0 FIND v(x01.xcore.m) AT=85.3u
meas tran m_x10_x01_b0 FIND v(x10.xcore.m) AT=85.3u
meas tran m_x11_x01_b0 FIND v(x11.xcore.m) AT=85.3u
meas tran smax_x01_b0 MAX v(diff) FROM=81.15u TO=83u
meas tran smin_x01_b0 MIN v(diff) FROM=81.15u TO=83u
meas tran ix_x01_b0 AVG i(Vixa1) FROM=82.2u TO=82.8u
meas tran iy_x01_b0 AVG i(Viya0) FROM=82.2u TO=82.8u
meas tran ii_x01_b0 AVG i(Vinh) FROM=82.2u TO=82.8u
meas tran m_x00_x10_w1 FIND v(x00.xcore.m) AT=91.3u
meas tran m_x01_x10_w1 FIND v(x01.xcore.m) AT=91.3u
meas tran m_x10_x10_w1 FIND v(x10.xcore.m) AT=91.3u
meas tran m_x11_x10_w1 FIND v(x11.xcore.m) AT=91.3u
meas tran smax_x10_w1 MAX v(diff) FROM=87.15u TO=89u
meas tran smin_x10_w1 MIN v(diff) FROM=87.15u TO=89u
meas tran ix_x10_w1 AVG i(Vixa0) FROM=88.2u TO=88.8u
meas tran iy_x10_w1 AVG i(Viya1) FROM=88.2u TO=88.8u
meas tran m_x00_x10_r1 FIND v(x00.xcore.m) AT=97.3u
meas tran m_x01_x10_r1 FIND v(x01.xcore.m) AT=97.3u
meas tran m_x10_x10_r1 FIND v(x10.xcore.m) AT=97.3u
meas tran m_x11_x10_r1 FIND v(x11.xcore.m) AT=97.3u
meas tran smax_x10_r1 MAX v(diff) FROM=93.15u TO=95u
meas tran smin_x10_r1 MIN v(diff) FROM=93.15u TO=95u
meas tran ix_x10_r1 AVG i(Vixa0) FROM=94.2u TO=94.8u
meas tran iy_x10_r1 AVG i(Viya1) FROM=94.2u TO=94.8u
meas tran m_x00_x10_b1 FIND v(x00.xcore.m) AT=103.3u
meas tran m_x01_x10_b1 FIND v(x01.xcore.m) AT=103.3u
meas tran m_x10_x10_b1 FIND v(x10.xcore.m) AT=103.3u
meas tran m_x11_x10_b1 FIND v(x11.xcore.m) AT=103.3u
meas tran smax_x10_b1 MAX v(diff) FROM=99.15u TO=101u
meas tran smin_x10_b1 MIN v(diff) FROM=99.15u TO=101u
meas tran ix_x10_b1 AVG i(Vixa0) FROM=100.2u TO=100.8u
meas tran iy_x10_b1 AVG i(Viya1) FROM=100.2u TO=100.8u
meas tran m_x00_x10_clr FIND v(x00.xcore.m) AT=109.3u
meas tran m_x01_x10_clr FIND v(x01.xcore.m) AT=109.3u
meas tran m_x10_x10_clr FIND v(x10.xcore.m) AT=109.3u
meas tran m_x11_x10_clr FIND v(x11.xcore.m) AT=109.3u
meas tran smax_x10_clr MAX v(diff) FROM=105.15u TO=107u
meas tran smin_x10_clr MIN v(diff) FROM=105.15u TO=107u
meas tran ix_x10_clr AVG i(Vixa0) FROM=106.2u TO=106.8u
meas tran iy_x10_clr AVG i(Viya1) FROM=106.2u TO=106.8u
meas tran m_x00_x10_w0 FIND v(x00.xcore.m) AT=115.3u
meas tran m_x01_x10_w0 FIND v(x01.xcore.m) AT=115.3u
meas tran m_x10_x10_w0 FIND v(x10.xcore.m) AT=115.3u
meas tran m_x11_x10_w0 FIND v(x11.xcore.m) AT=115.3u
meas tran smax_x10_w0 MAX v(diff) FROM=111.15u TO=113u
meas tran smin_x10_w0 MIN v(diff) FROM=111.15u TO=113u
meas tran ix_x10_w0 AVG i(Vixa0) FROM=112.2u TO=112.8u
meas tran iy_x10_w0 AVG i(Viya1) FROM=112.2u TO=112.8u
meas tran ii_x10_w0 AVG i(Vinh) FROM=112.2u TO=112.8u
meas tran m_x00_x10_r0 FIND v(x00.xcore.m) AT=121.3u
meas tran m_x01_x10_r0 FIND v(x01.xcore.m) AT=121.3u
meas tran m_x10_x10_r0 FIND v(x10.xcore.m) AT=121.3u
meas tran m_x11_x10_r0 FIND v(x11.xcore.m) AT=121.3u
meas tran smax_x10_r0 MAX v(diff) FROM=117.15u TO=119u
meas tran smin_x10_r0 MIN v(diff) FROM=117.15u TO=119u
meas tran ix_x10_r0 AVG i(Vixa0) FROM=118.2u TO=118.8u
meas tran iy_x10_r0 AVG i(Viya1) FROM=118.2u TO=118.8u
meas tran m_x00_x10_b0 FIND v(x00.xcore.m) AT=127.3u
meas tran m_x01_x10_b0 FIND v(x01.xcore.m) AT=127.3u
meas tran m_x10_x10_b0 FIND v(x10.xcore.m) AT=127.3u
meas tran m_x11_x10_b0 FIND v(x11.xcore.m) AT=127.3u
meas tran smax_x10_b0 MAX v(diff) FROM=123.15u TO=125u
meas tran smin_x10_b0 MIN v(diff) FROM=123.15u TO=125u
meas tran ix_x10_b0 AVG i(Vixa0) FROM=124.2u TO=124.8u
meas tran iy_x10_b0 AVG i(Viya1) FROM=124.2u TO=124.8u
meas tran ii_x10_b0 AVG i(Vinh) FROM=124.2u TO=124.8u
meas tran m_x00_x11_w1 FIND v(x00.xcore.m) AT=133.3u
meas tran m_x01_x11_w1 FIND v(x01.xcore.m) AT=133.3u
meas tran m_x10_x11_w1 FIND v(x10.xcore.m) AT=133.3u
meas tran m_x11_x11_w1 FIND v(x11.xcore.m) AT=133.3u
meas tran smax_x11_w1 MAX v(diff) FROM=129.15u TO=131u
meas tran smin_x11_w1 MIN v(diff) FROM=129.15u TO=131u
meas tran ix_x11_w1 AVG i(Vixa1) FROM=130.2u TO=130.8u
meas tran iy_x11_w1 AVG i(Viya1) FROM=130.2u TO=130.8u
meas tran m_x00_x11_r1 FIND v(x00.xcore.m) AT=139.3u
meas tran m_x01_x11_r1 FIND v(x01.xcore.m) AT=139.3u
meas tran m_x10_x11_r1 FIND v(x10.xcore.m) AT=139.3u
meas tran m_x11_x11_r1 FIND v(x11.xcore.m) AT=139.3u
meas tran smax_x11_r1 MAX v(diff) FROM=135.15u TO=137u
meas tran smin_x11_r1 MIN v(diff) FROM=135.15u TO=137u
meas tran ix_x11_r1 AVG i(Vixa1) FROM=136.2u TO=136.8u
meas tran iy_x11_r1 AVG i(Viya1) FROM=136.2u TO=136.8u
meas tran m_x00_x11_b1 FIND v(x00.xcore.m) AT=145.3u
meas tran m_x01_x11_b1 FIND v(x01.xcore.m) AT=145.3u
meas tran m_x10_x11_b1 FIND v(x10.xcore.m) AT=145.3u
meas tran m_x11_x11_b1 FIND v(x11.xcore.m) AT=145.3u
meas tran smax_x11_b1 MAX v(diff) FROM=141.15u TO=143u
meas tran smin_x11_b1 MIN v(diff) FROM=141.15u TO=143u
meas tran ix_x11_b1 AVG i(Vixa1) FROM=142.2u TO=142.8u
meas tran iy_x11_b1 AVG i(Viya1) FROM=142.2u TO=142.8u
meas tran m_x00_x11_clr FIND v(x00.xcore.m) AT=151.3u
meas tran m_x01_x11_clr FIND v(x01.xcore.m) AT=151.3u
meas tran m_x10_x11_clr FIND v(x10.xcore.m) AT=151.3u
meas tran m_x11_x11_clr FIND v(x11.xcore.m) AT=151.3u
meas tran smax_x11_clr MAX v(diff) FROM=147.15u TO=149u
meas tran smin_x11_clr MIN v(diff) FROM=147.15u TO=149u
meas tran ix_x11_clr AVG i(Vixa1) FROM=148.2u TO=148.8u
meas tran iy_x11_clr AVG i(Viya1) FROM=148.2u TO=148.8u
meas tran m_x00_x11_w0 FIND v(x00.xcore.m) AT=157.3u
meas tran m_x01_x11_w0 FIND v(x01.xcore.m) AT=157.3u
meas tran m_x10_x11_w0 FIND v(x10.xcore.m) AT=157.3u
meas tran m_x11_x11_w0 FIND v(x11.xcore.m) AT=157.3u
meas tran smax_x11_w0 MAX v(diff) FROM=153.15u TO=155u
meas tran smin_x11_w0 MIN v(diff) FROM=153.15u TO=155u
meas tran ix_x11_w0 AVG i(Vixa1) FROM=154.2u TO=154.8u
meas tran iy_x11_w0 AVG i(Viya1) FROM=154.2u TO=154.8u
meas tran ii_x11_w0 AVG i(Vinh) FROM=154.2u TO=154.8u
meas tran m_x00_x11_r0 FIND v(x00.xcore.m) AT=163.3u
meas tran m_x01_x11_r0 FIND v(x01.xcore.m) AT=163.3u
meas tran m_x10_x11_r0 FIND v(x10.xcore.m) AT=163.3u
meas tran m_x11_x11_r0 FIND v(x11.xcore.m) AT=163.3u
meas tran smax_x11_r0 MAX v(diff) FROM=159.15u TO=161u
meas tran smin_x11_r0 MIN v(diff) FROM=159.15u TO=161u
meas tran ix_x11_r0 AVG i(Vixa1) FROM=160.2u TO=160.8u
meas tran iy_x11_r0 AVG i(Viya1) FROM=160.2u TO=160.8u
meas tran m_x00_x11_b0 FIND v(x00.xcore.m) AT=169.3u
meas tran m_x01_x11_b0 FIND v(x01.xcore.m) AT=169.3u
meas tran m_x10_x11_b0 FIND v(x10.xcore.m) AT=169.3u
meas tran m_x11_x11_b0 FIND v(x11.xcore.m) AT=169.3u
meas tran smax_x11_b0 MAX v(diff) FROM=165.15u TO=167u
meas tran smin_x11_b0 MIN v(diff) FROM=165.15u TO=167u
meas tran ix_x11_b0 AVG i(Vixa1) FROM=166.2u TO=166.8u
meas tran iy_x11_b0 AVG i(Viya1) FROM=166.2u TO=166.8u
meas tran ii_x11_b0 AVG i(Vinh) FROM=166.2u TO=166.8u

print m_x00_x00_w1 m_x01_x00_w1 m_x10_x00_w1 m_x11_x00_w1 smax_x00_w1 smin_x00_w1 ix_x00_w1 iy_x00_w1
print m_x00_x00_r1 m_x01_x00_r1 m_x10_x00_r1 m_x11_x00_r1 smax_x00_r1 smin_x00_r1 ix_x00_r1 iy_x00_r1
print m_x00_x00_b1 m_x01_x00_b1 m_x10_x00_b1 m_x11_x00_b1 smax_x00_b1 smin_x00_b1 ix_x00_b1 iy_x00_b1
print m_x00_x00_clr m_x01_x00_clr m_x10_x00_clr m_x11_x00_clr smax_x00_clr smin_x00_clr ix_x00_clr iy_x00_clr
print m_x00_x00_w0 m_x01_x00_w0 m_x10_x00_w0 m_x11_x00_w0 smax_x00_w0 smin_x00_w0 ix_x00_w0 iy_x00_w0 ii_x00_w0
print m_x00_x00_r0 m_x01_x00_r0 m_x10_x00_r0 m_x11_x00_r0 smax_x00_r0 smin_x00_r0 ix_x00_r0 iy_x00_r0
print m_x00_x00_b0 m_x01_x00_b0 m_x10_x00_b0 m_x11_x00_b0 smax_x00_b0 smin_x00_b0 ix_x00_b0 iy_x00_b0 ii_x00_b0
print m_x00_x01_w1 m_x01_x01_w1 m_x10_x01_w1 m_x11_x01_w1 smax_x01_w1 smin_x01_w1 ix_x01_w1 iy_x01_w1
print m_x00_x01_r1 m_x01_x01_r1 m_x10_x01_r1 m_x11_x01_r1 smax_x01_r1 smin_x01_r1 ix_x01_r1 iy_x01_r1
print m_x00_x01_b1 m_x01_x01_b1 m_x10_x01_b1 m_x11_x01_b1 smax_x01_b1 smin_x01_b1 ix_x01_b1 iy_x01_b1
print m_x00_x01_clr m_x01_x01_clr m_x10_x01_clr m_x11_x01_clr smax_x01_clr smin_x01_clr ix_x01_clr iy_x01_clr
print m_x00_x01_w0 m_x01_x01_w0 m_x10_x01_w0 m_x11_x01_w0 smax_x01_w0 smin_x01_w0 ix_x01_w0 iy_x01_w0 ii_x01_w0
print m_x00_x01_r0 m_x01_x01_r0 m_x10_x01_r0 m_x11_x01_r0 smax_x01_r0 smin_x01_r0 ix_x01_r0 iy_x01_r0
print m_x00_x01_b0 m_x01_x01_b0 m_x10_x01_b0 m_x11_x01_b0 smax_x01_b0 smin_x01_b0 ix_x01_b0 iy_x01_b0 ii_x01_b0
print m_x00_x10_w1 m_x01_x10_w1 m_x10_x10_w1 m_x11_x10_w1 smax_x10_w1 smin_x10_w1 ix_x10_w1 iy_x10_w1
print m_x00_x10_r1 m_x01_x10_r1 m_x10_x10_r1 m_x11_x10_r1 smax_x10_r1 smin_x10_r1 ix_x10_r1 iy_x10_r1
print m_x00_x10_b1 m_x01_x10_b1 m_x10_x10_b1 m_x11_x10_b1 smax_x10_b1 smin_x10_b1 ix_x10_b1 iy_x10_b1
print m_x00_x10_clr m_x01_x10_clr m_x10_x10_clr m_x11_x10_clr smax_x10_clr smin_x10_clr ix_x10_clr iy_x10_clr
print m_x00_x10_w0 m_x01_x10_w0 m_x10_x10_w0 m_x11_x10_w0 smax_x10_w0 smin_x10_w0 ix_x10_w0 iy_x10_w0 ii_x10_w0
print m_x00_x10_r0 m_x01_x10_r0 m_x10_x10_r0 m_x11_x10_r0 smax_x10_r0 smin_x10_r0 ix_x10_r0 iy_x10_r0
print m_x00_x10_b0 m_x01_x10_b0 m_x10_x10_b0 m_x11_x10_b0 smax_x10_b0 smin_x10_b0 ix_x10_b0 iy_x10_b0 ii_x10_b0
print m_x00_x11_w1 m_x01_x11_w1 m_x10_x11_w1 m_x11_x11_w1 smax_x11_w1 smin_x11_w1 ix_x11_w1 iy_x11_w1
print m_x00_x11_r1 m_x01_x11_r1 m_x10_x11_r1 m_x11_x11_r1 smax_x11_r1 smin_x11_r1 ix_x11_r1 iy_x11_r1
print m_x00_x11_b1 m_x01_x11_b1 m_x10_x11_b1 m_x11_x11_b1 smax_x11_b1 smin_x11_b1 ix_x11_b1 iy_x11_b1
print m_x00_x11_clr m_x01_x11_clr m_x10_x11_clr m_x11_x11_clr smax_x11_clr smin_x11_clr ix_x11_clr iy_x11_clr
print m_x00_x11_w0 m_x01_x11_w0 m_x10_x11_w0 m_x11_x11_w0 smax_x11_w0 smin_x11_w0 ix_x11_w0 iy_x11_w0 ii_x11_w0
print m_x00_x11_r0 m_x01_x11_r0 m_x10_x11_r0 m_x11_x11_r0 smax_x11_r0 smin_x11_r0 ix_x11_r0 iy_x11_r0
print m_x00_x11_b0 m_x01_x11_b0 m_x10_x11_b0 m_x11_x11_b0 smax_x11_b0 smin_x11_b0 ix_x11_b0 iy_x11_b0 ii_x11_b0

let fail = 0

if m_x00_x00_w1 < 0.9
  let fail = 1
  echo FAIL X00 write 1 did not set X00
end
if m_x01_x00_w1 > -0.9
  let fail = 1
  echo FAIL X00 write 1 left X01 high
end
if m_x10_x00_w1 > -0.9
  let fail = 1
  echo FAIL X00 write 1 left X10 high
end
if m_x11_x00_w1 > -0.9
  let fail = 1
  echo FAIL X00 write 1 left X11 high
end
let pk = smax_x00_w1
if abs(smin_x00_w1) > pk
  let pk = abs(smin_x00_w1)
end
if pk < 15m
  let fail = 1
  echo FAIL X00 write 1 sense below 15 mV
end
if pk > 80m
  let fail = 1
  echo FAIL X00 write 1 sense above 80 mV
end
if ix_x00_w1 < 0.34
  let fail = 1
  echo FAIL X00 write 1 X current low
end
if ix_x00_w1 > 0.46
  let fail = 1
  echo FAIL X00 write 1 X current high
end
if iy_x00_w1 < 0.34
  let fail = 1
  echo FAIL X00 write 1 Y current low
end
if iy_x00_w1 > 0.46
  let fail = 1
  echo FAIL X00 write 1 Y current high
end
if m_x00_x00_r1 > -0.9
  let fail = 1
  echo FAIL X00 read 1 left X00 high
end
if m_x01_x00_r1 > -0.9
  let fail = 1
  echo FAIL X00 read 1 left X01 high
end
if m_x10_x00_r1 > -0.9
  let fail = 1
  echo FAIL X00 read 1 left X10 high
end
if m_x11_x00_r1 > -0.9
  let fail = 1
  echo FAIL X00 read 1 left X11 high
end
let pk = smax_x00_r1
if abs(smin_x00_r1) > pk
  let pk = abs(smin_x00_r1)
end
if pk < 15m
  let fail = 1
  echo FAIL X00 read 1 sense below 15 mV
end
if pk > 80m
  let fail = 1
  echo FAIL X00 read 1 sense above 80 mV
end
if ix_x00_r1 > -0.34
  let fail = 1
  echo FAIL X00 read 1 X current weak
end
if ix_x00_r1 < -0.46
  let fail = 1
  echo FAIL X00 read 1 X current strong
end
if iy_x00_r1 > -0.34
  let fail = 1
  echo FAIL X00 read 1 Y current weak
end
if iy_x00_r1 < -0.46
  let fail = 1
  echo FAIL X00 read 1 Y current strong
end
if m_x00_x00_b1 < 0.9
  let fail = 1
  echo FAIL X00 write-back 1 did not set X00
end
if m_x01_x00_b1 > -0.9
  let fail = 1
  echo FAIL X00 write-back 1 left X01 high
end
if m_x10_x00_b1 > -0.9
  let fail = 1
  echo FAIL X00 write-back 1 left X10 high
end
if m_x11_x00_b1 > -0.9
  let fail = 1
  echo FAIL X00 write-back 1 left X11 high
end
let pk = smax_x00_b1
if abs(smin_x00_b1) > pk
  let pk = abs(smin_x00_b1)
end
if pk < 15m
  let fail = 1
  echo FAIL X00 write-back 1 sense below 15 mV
end
if pk > 80m
  let fail = 1
  echo FAIL X00 write-back 1 sense above 80 mV
end
if ix_x00_b1 < 0.34
  let fail = 1
  echo FAIL X00 write-back 1 X current low
end
if ix_x00_b1 > 0.46
  let fail = 1
  echo FAIL X00 write-back 1 X current high
end
if iy_x00_b1 < 0.34
  let fail = 1
  echo FAIL X00 write-back 1 Y current low
end
if iy_x00_b1 > 0.46
  let fail = 1
  echo FAIL X00 write-back 1 Y current high
end
if m_x00_x00_clr > -0.9
  let fail = 1
  echo FAIL X00 clear left X00 high
end
if m_x01_x00_clr > -0.9
  let fail = 1
  echo FAIL X00 clear left X01 high
end
if m_x10_x00_clr > -0.9
  let fail = 1
  echo FAIL X00 clear left X10 high
end
if m_x11_x00_clr > -0.9
  let fail = 1
  echo FAIL X00 clear left X11 high
end
let pk = smax_x00_clr
if abs(smin_x00_clr) > pk
  let pk = abs(smin_x00_clr)
end
if pk < 15m
  let fail = 1
  echo FAIL X00 clear sense below 15 mV
end
if pk > 80m
  let fail = 1
  echo FAIL X00 clear sense above 80 mV
end
if ix_x00_clr > -0.34
  let fail = 1
  echo FAIL X00 clear X current weak
end
if ix_x00_clr < -0.46
  let fail = 1
  echo FAIL X00 clear X current strong
end
if iy_x00_clr > -0.34
  let fail = 1
  echo FAIL X00 clear Y current weak
end
if iy_x00_clr < -0.46
  let fail = 1
  echo FAIL X00 clear Y current strong
end
if m_x00_x00_w0 > -0.9
  let fail = 1
  echo FAIL X00 write 0 left X00 high
end
if m_x01_x00_w0 > -0.9
  let fail = 1
  echo FAIL X00 write 0 left X01 high
end
if m_x10_x00_w0 > -0.9
  let fail = 1
  echo FAIL X00 write 0 left X10 high
end
if m_x11_x00_w0 > -0.9
  let fail = 1
  echo FAIL X00 write 0 left X11 high
end
let pk = smax_x00_w0
if abs(smin_x00_w0) > pk
  let pk = abs(smin_x00_w0)
end
if pk > 15m
  let fail = 1
  echo FAIL X00 write 0 produced a flip plateau
end
if ix_x00_w0 < 0.34
  let fail = 1
  echo FAIL X00 write 0 X current low
end
if ix_x00_w0 > 0.46
  let fail = 1
  echo FAIL X00 write 0 X current high
end
if iy_x00_w0 < 0.34
  let fail = 1
  echo FAIL X00 write 0 Y current low
end
if iy_x00_w0 > 0.46
  let fail = 1
  echo FAIL X00 write 0 Y current high
end
if ii_x00_w0 < 0.34
  let fail = 1
  echo FAIL X00 write 0 inhibit current low
end
if ii_x00_w0 > 0.46
  let fail = 1
  echo FAIL X00 write 0 inhibit current high
end
if m_x00_x00_r0 > -0.9
  let fail = 1
  echo FAIL X00 read 0 left X00 high
end
if m_x01_x00_r0 > -0.9
  let fail = 1
  echo FAIL X00 read 0 left X01 high
end
if m_x10_x00_r0 > -0.9
  let fail = 1
  echo FAIL X00 read 0 left X10 high
end
if m_x11_x00_r0 > -0.9
  let fail = 1
  echo FAIL X00 read 0 left X11 high
end
let pk = smax_x00_r0
if abs(smin_x00_r0) > pk
  let pk = abs(smin_x00_r0)
end
if pk > 15m
  let fail = 1
  echo FAIL X00 read 0 produced a flip plateau
end
if ix_x00_r0 > -0.34
  let fail = 1
  echo FAIL X00 read 0 X current weak
end
if ix_x00_r0 < -0.46
  let fail = 1
  echo FAIL X00 read 0 X current strong
end
if iy_x00_r0 > -0.34
  let fail = 1
  echo FAIL X00 read 0 Y current weak
end
if iy_x00_r0 < -0.46
  let fail = 1
  echo FAIL X00 read 0 Y current strong
end
if m_x00_x00_b0 > -0.9
  let fail = 1
  echo FAIL X00 write-back 0 left X00 high
end
if m_x01_x00_b0 > -0.9
  let fail = 1
  echo FAIL X00 write-back 0 left X01 high
end
if m_x10_x00_b0 > -0.9
  let fail = 1
  echo FAIL X00 write-back 0 left X10 high
end
if m_x11_x00_b0 > -0.9
  let fail = 1
  echo FAIL X00 write-back 0 left X11 high
end
let pk = smax_x00_b0
if abs(smin_x00_b0) > pk
  let pk = abs(smin_x00_b0)
end
if pk > 15m
  let fail = 1
  echo FAIL X00 write-back 0 produced a flip plateau
end
if ix_x00_b0 < 0.34
  let fail = 1
  echo FAIL X00 write-back 0 X current low
end
if ix_x00_b0 > 0.46
  let fail = 1
  echo FAIL X00 write-back 0 X current high
end
if iy_x00_b0 < 0.34
  let fail = 1
  echo FAIL X00 write-back 0 Y current low
end
if iy_x00_b0 > 0.46
  let fail = 1
  echo FAIL X00 write-back 0 Y current high
end
if ii_x00_b0 < 0.34
  let fail = 1
  echo FAIL X00 write-back 0 inhibit current low
end
if ii_x00_b0 > 0.46
  let fail = 1
  echo FAIL X00 write-back 0 inhibit current high
end
if m_x00_x01_w1 > -0.9
  let fail = 1
  echo FAIL X01 write 1 left X00 high
end
if m_x01_x01_w1 < 0.9
  let fail = 1
  echo FAIL X01 write 1 did not set X01
end
if m_x10_x01_w1 > -0.9
  let fail = 1
  echo FAIL X01 write 1 left X10 high
end
if m_x11_x01_w1 > -0.9
  let fail = 1
  echo FAIL X01 write 1 left X11 high
end
let pk = smax_x01_w1
if abs(smin_x01_w1) > pk
  let pk = abs(smin_x01_w1)
end
if pk < 15m
  let fail = 1
  echo FAIL X01 write 1 sense below 15 mV
end
if pk > 80m
  let fail = 1
  echo FAIL X01 write 1 sense above 80 mV
end
if ix_x01_w1 < 0.34
  let fail = 1
  echo FAIL X01 write 1 X current low
end
if ix_x01_w1 > 0.46
  let fail = 1
  echo FAIL X01 write 1 X current high
end
if iy_x01_w1 < 0.34
  let fail = 1
  echo FAIL X01 write 1 Y current low
end
if iy_x01_w1 > 0.46
  let fail = 1
  echo FAIL X01 write 1 Y current high
end
if m_x00_x01_r1 > -0.9
  let fail = 1
  echo FAIL X01 read 1 left X00 high
end
if m_x01_x01_r1 > -0.9
  let fail = 1
  echo FAIL X01 read 1 left X01 high
end
if m_x10_x01_r1 > -0.9
  let fail = 1
  echo FAIL X01 read 1 left X10 high
end
if m_x11_x01_r1 > -0.9
  let fail = 1
  echo FAIL X01 read 1 left X11 high
end
let pk = smax_x01_r1
if abs(smin_x01_r1) > pk
  let pk = abs(smin_x01_r1)
end
if pk < 15m
  let fail = 1
  echo FAIL X01 read 1 sense below 15 mV
end
if pk > 80m
  let fail = 1
  echo FAIL X01 read 1 sense above 80 mV
end
if ix_x01_r1 > -0.34
  let fail = 1
  echo FAIL X01 read 1 X current weak
end
if ix_x01_r1 < -0.46
  let fail = 1
  echo FAIL X01 read 1 X current strong
end
if iy_x01_r1 > -0.34
  let fail = 1
  echo FAIL X01 read 1 Y current weak
end
if iy_x01_r1 < -0.46
  let fail = 1
  echo FAIL X01 read 1 Y current strong
end
if m_x00_x01_b1 > -0.9
  let fail = 1
  echo FAIL X01 write-back 1 left X00 high
end
if m_x01_x01_b1 < 0.9
  let fail = 1
  echo FAIL X01 write-back 1 did not set X01
end
if m_x10_x01_b1 > -0.9
  let fail = 1
  echo FAIL X01 write-back 1 left X10 high
end
if m_x11_x01_b1 > -0.9
  let fail = 1
  echo FAIL X01 write-back 1 left X11 high
end
let pk = smax_x01_b1
if abs(smin_x01_b1) > pk
  let pk = abs(smin_x01_b1)
end
if pk < 15m
  let fail = 1
  echo FAIL X01 write-back 1 sense below 15 mV
end
if pk > 80m
  let fail = 1
  echo FAIL X01 write-back 1 sense above 80 mV
end
if ix_x01_b1 < 0.34
  let fail = 1
  echo FAIL X01 write-back 1 X current low
end
if ix_x01_b1 > 0.46
  let fail = 1
  echo FAIL X01 write-back 1 X current high
end
if iy_x01_b1 < 0.34
  let fail = 1
  echo FAIL X01 write-back 1 Y current low
end
if iy_x01_b1 > 0.46
  let fail = 1
  echo FAIL X01 write-back 1 Y current high
end
if m_x00_x01_clr > -0.9
  let fail = 1
  echo FAIL X01 clear left X00 high
end
if m_x01_x01_clr > -0.9
  let fail = 1
  echo FAIL X01 clear left X01 high
end
if m_x10_x01_clr > -0.9
  let fail = 1
  echo FAIL X01 clear left X10 high
end
if m_x11_x01_clr > -0.9
  let fail = 1
  echo FAIL X01 clear left X11 high
end
let pk = smax_x01_clr
if abs(smin_x01_clr) > pk
  let pk = abs(smin_x01_clr)
end
if pk < 15m
  let fail = 1
  echo FAIL X01 clear sense below 15 mV
end
if pk > 80m
  let fail = 1
  echo FAIL X01 clear sense above 80 mV
end
if ix_x01_clr > -0.34
  let fail = 1
  echo FAIL X01 clear X current weak
end
if ix_x01_clr < -0.46
  let fail = 1
  echo FAIL X01 clear X current strong
end
if iy_x01_clr > -0.34
  let fail = 1
  echo FAIL X01 clear Y current weak
end
if iy_x01_clr < -0.46
  let fail = 1
  echo FAIL X01 clear Y current strong
end
if m_x00_x01_w0 > -0.9
  let fail = 1
  echo FAIL X01 write 0 left X00 high
end
if m_x01_x01_w0 > -0.9
  let fail = 1
  echo FAIL X01 write 0 left X01 high
end
if m_x10_x01_w0 > -0.9
  let fail = 1
  echo FAIL X01 write 0 left X10 high
end
if m_x11_x01_w0 > -0.9
  let fail = 1
  echo FAIL X01 write 0 left X11 high
end
let pk = smax_x01_w0
if abs(smin_x01_w0) > pk
  let pk = abs(smin_x01_w0)
end
if pk > 15m
  let fail = 1
  echo FAIL X01 write 0 produced a flip plateau
end
if ix_x01_w0 < 0.34
  let fail = 1
  echo FAIL X01 write 0 X current low
end
if ix_x01_w0 > 0.46
  let fail = 1
  echo FAIL X01 write 0 X current high
end
if iy_x01_w0 < 0.34
  let fail = 1
  echo FAIL X01 write 0 Y current low
end
if iy_x01_w0 > 0.46
  let fail = 1
  echo FAIL X01 write 0 Y current high
end
if ii_x01_w0 < 0.34
  let fail = 1
  echo FAIL X01 write 0 inhibit current low
end
if ii_x01_w0 > 0.46
  let fail = 1
  echo FAIL X01 write 0 inhibit current high
end
if m_x00_x01_r0 > -0.9
  let fail = 1
  echo FAIL X01 read 0 left X00 high
end
if m_x01_x01_r0 > -0.9
  let fail = 1
  echo FAIL X01 read 0 left X01 high
end
if m_x10_x01_r0 > -0.9
  let fail = 1
  echo FAIL X01 read 0 left X10 high
end
if m_x11_x01_r0 > -0.9
  let fail = 1
  echo FAIL X01 read 0 left X11 high
end
let pk = smax_x01_r0
if abs(smin_x01_r0) > pk
  let pk = abs(smin_x01_r0)
end
if pk > 15m
  let fail = 1
  echo FAIL X01 read 0 produced a flip plateau
end
if ix_x01_r0 > -0.34
  let fail = 1
  echo FAIL X01 read 0 X current weak
end
if ix_x01_r0 < -0.46
  let fail = 1
  echo FAIL X01 read 0 X current strong
end
if iy_x01_r0 > -0.34
  let fail = 1
  echo FAIL X01 read 0 Y current weak
end
if iy_x01_r0 < -0.46
  let fail = 1
  echo FAIL X01 read 0 Y current strong
end
if m_x00_x01_b0 > -0.9
  let fail = 1
  echo FAIL X01 write-back 0 left X00 high
end
if m_x01_x01_b0 > -0.9
  let fail = 1
  echo FAIL X01 write-back 0 left X01 high
end
if m_x10_x01_b0 > -0.9
  let fail = 1
  echo FAIL X01 write-back 0 left X10 high
end
if m_x11_x01_b0 > -0.9
  let fail = 1
  echo FAIL X01 write-back 0 left X11 high
end
let pk = smax_x01_b0
if abs(smin_x01_b0) > pk
  let pk = abs(smin_x01_b0)
end
if pk > 15m
  let fail = 1
  echo FAIL X01 write-back 0 produced a flip plateau
end
if ix_x01_b0 < 0.34
  let fail = 1
  echo FAIL X01 write-back 0 X current low
end
if ix_x01_b0 > 0.46
  let fail = 1
  echo FAIL X01 write-back 0 X current high
end
if iy_x01_b0 < 0.34
  let fail = 1
  echo FAIL X01 write-back 0 Y current low
end
if iy_x01_b0 > 0.46
  let fail = 1
  echo FAIL X01 write-back 0 Y current high
end
if ii_x01_b0 < 0.34
  let fail = 1
  echo FAIL X01 write-back 0 inhibit current low
end
if ii_x01_b0 > 0.46
  let fail = 1
  echo FAIL X01 write-back 0 inhibit current high
end
if m_x00_x10_w1 > -0.9
  let fail = 1
  echo FAIL X10 write 1 left X00 high
end
if m_x01_x10_w1 > -0.9
  let fail = 1
  echo FAIL X10 write 1 left X01 high
end
if m_x10_x10_w1 < 0.9
  let fail = 1
  echo FAIL X10 write 1 did not set X10
end
if m_x11_x10_w1 > -0.9
  let fail = 1
  echo FAIL X10 write 1 left X11 high
end
let pk = smax_x10_w1
if abs(smin_x10_w1) > pk
  let pk = abs(smin_x10_w1)
end
if pk < 15m
  let fail = 1
  echo FAIL X10 write 1 sense below 15 mV
end
if pk > 80m
  let fail = 1
  echo FAIL X10 write 1 sense above 80 mV
end
if ix_x10_w1 < 0.34
  let fail = 1
  echo FAIL X10 write 1 X current low
end
if ix_x10_w1 > 0.46
  let fail = 1
  echo FAIL X10 write 1 X current high
end
if iy_x10_w1 < 0.34
  let fail = 1
  echo FAIL X10 write 1 Y current low
end
if iy_x10_w1 > 0.46
  let fail = 1
  echo FAIL X10 write 1 Y current high
end
if m_x00_x10_r1 > -0.9
  let fail = 1
  echo FAIL X10 read 1 left X00 high
end
if m_x01_x10_r1 > -0.9
  let fail = 1
  echo FAIL X10 read 1 left X01 high
end
if m_x10_x10_r1 > -0.9
  let fail = 1
  echo FAIL X10 read 1 left X10 high
end
if m_x11_x10_r1 > -0.9
  let fail = 1
  echo FAIL X10 read 1 left X11 high
end
let pk = smax_x10_r1
if abs(smin_x10_r1) > pk
  let pk = abs(smin_x10_r1)
end
if pk < 15m
  let fail = 1
  echo FAIL X10 read 1 sense below 15 mV
end
if pk > 80m
  let fail = 1
  echo FAIL X10 read 1 sense above 80 mV
end
if ix_x10_r1 > -0.34
  let fail = 1
  echo FAIL X10 read 1 X current weak
end
if ix_x10_r1 < -0.46
  let fail = 1
  echo FAIL X10 read 1 X current strong
end
if iy_x10_r1 > -0.34
  let fail = 1
  echo FAIL X10 read 1 Y current weak
end
if iy_x10_r1 < -0.46
  let fail = 1
  echo FAIL X10 read 1 Y current strong
end
if m_x00_x10_b1 > -0.9
  let fail = 1
  echo FAIL X10 write-back 1 left X00 high
end
if m_x01_x10_b1 > -0.9
  let fail = 1
  echo FAIL X10 write-back 1 left X01 high
end
if m_x10_x10_b1 < 0.9
  let fail = 1
  echo FAIL X10 write-back 1 did not set X10
end
if m_x11_x10_b1 > -0.9
  let fail = 1
  echo FAIL X10 write-back 1 left X11 high
end
let pk = smax_x10_b1
if abs(smin_x10_b1) > pk
  let pk = abs(smin_x10_b1)
end
if pk < 15m
  let fail = 1
  echo FAIL X10 write-back 1 sense below 15 mV
end
if pk > 80m
  let fail = 1
  echo FAIL X10 write-back 1 sense above 80 mV
end
if ix_x10_b1 < 0.34
  let fail = 1
  echo FAIL X10 write-back 1 X current low
end
if ix_x10_b1 > 0.46
  let fail = 1
  echo FAIL X10 write-back 1 X current high
end
if iy_x10_b1 < 0.34
  let fail = 1
  echo FAIL X10 write-back 1 Y current low
end
if iy_x10_b1 > 0.46
  let fail = 1
  echo FAIL X10 write-back 1 Y current high
end
if m_x00_x10_clr > -0.9
  let fail = 1
  echo FAIL X10 clear left X00 high
end
if m_x01_x10_clr > -0.9
  let fail = 1
  echo FAIL X10 clear left X01 high
end
if m_x10_x10_clr > -0.9
  let fail = 1
  echo FAIL X10 clear left X10 high
end
if m_x11_x10_clr > -0.9
  let fail = 1
  echo FAIL X10 clear left X11 high
end
let pk = smax_x10_clr
if abs(smin_x10_clr) > pk
  let pk = abs(smin_x10_clr)
end
if pk < 15m
  let fail = 1
  echo FAIL X10 clear sense below 15 mV
end
if pk > 80m
  let fail = 1
  echo FAIL X10 clear sense above 80 mV
end
if ix_x10_clr > -0.34
  let fail = 1
  echo FAIL X10 clear X current weak
end
if ix_x10_clr < -0.46
  let fail = 1
  echo FAIL X10 clear X current strong
end
if iy_x10_clr > -0.34
  let fail = 1
  echo FAIL X10 clear Y current weak
end
if iy_x10_clr < -0.46
  let fail = 1
  echo FAIL X10 clear Y current strong
end
if m_x00_x10_w0 > -0.9
  let fail = 1
  echo FAIL X10 write 0 left X00 high
end
if m_x01_x10_w0 > -0.9
  let fail = 1
  echo FAIL X10 write 0 left X01 high
end
if m_x10_x10_w0 > -0.9
  let fail = 1
  echo FAIL X10 write 0 left X10 high
end
if m_x11_x10_w0 > -0.9
  let fail = 1
  echo FAIL X10 write 0 left X11 high
end
let pk = smax_x10_w0
if abs(smin_x10_w0) > pk
  let pk = abs(smin_x10_w0)
end
if pk > 15m
  let fail = 1
  echo FAIL X10 write 0 produced a flip plateau
end
if ix_x10_w0 < 0.34
  let fail = 1
  echo FAIL X10 write 0 X current low
end
if ix_x10_w0 > 0.46
  let fail = 1
  echo FAIL X10 write 0 X current high
end
if iy_x10_w0 < 0.34
  let fail = 1
  echo FAIL X10 write 0 Y current low
end
if iy_x10_w0 > 0.46
  let fail = 1
  echo FAIL X10 write 0 Y current high
end
if ii_x10_w0 < 0.34
  let fail = 1
  echo FAIL X10 write 0 inhibit current low
end
if ii_x10_w0 > 0.46
  let fail = 1
  echo FAIL X10 write 0 inhibit current high
end
if m_x00_x10_r0 > -0.9
  let fail = 1
  echo FAIL X10 read 0 left X00 high
end
if m_x01_x10_r0 > -0.9
  let fail = 1
  echo FAIL X10 read 0 left X01 high
end
if m_x10_x10_r0 > -0.9
  let fail = 1
  echo FAIL X10 read 0 left X10 high
end
if m_x11_x10_r0 > -0.9
  let fail = 1
  echo FAIL X10 read 0 left X11 high
end
let pk = smax_x10_r0
if abs(smin_x10_r0) > pk
  let pk = abs(smin_x10_r0)
end
if pk > 15m
  let fail = 1
  echo FAIL X10 read 0 produced a flip plateau
end
if ix_x10_r0 > -0.34
  let fail = 1
  echo FAIL X10 read 0 X current weak
end
if ix_x10_r0 < -0.46
  let fail = 1
  echo FAIL X10 read 0 X current strong
end
if iy_x10_r0 > -0.34
  let fail = 1
  echo FAIL X10 read 0 Y current weak
end
if iy_x10_r0 < -0.46
  let fail = 1
  echo FAIL X10 read 0 Y current strong
end
if m_x00_x10_b0 > -0.9
  let fail = 1
  echo FAIL X10 write-back 0 left X00 high
end
if m_x01_x10_b0 > -0.9
  let fail = 1
  echo FAIL X10 write-back 0 left X01 high
end
if m_x10_x10_b0 > -0.9
  let fail = 1
  echo FAIL X10 write-back 0 left X10 high
end
if m_x11_x10_b0 > -0.9
  let fail = 1
  echo FAIL X10 write-back 0 left X11 high
end
let pk = smax_x10_b0
if abs(smin_x10_b0) > pk
  let pk = abs(smin_x10_b0)
end
if pk > 15m
  let fail = 1
  echo FAIL X10 write-back 0 produced a flip plateau
end
if ix_x10_b0 < 0.34
  let fail = 1
  echo FAIL X10 write-back 0 X current low
end
if ix_x10_b0 > 0.46
  let fail = 1
  echo FAIL X10 write-back 0 X current high
end
if iy_x10_b0 < 0.34
  let fail = 1
  echo FAIL X10 write-back 0 Y current low
end
if iy_x10_b0 > 0.46
  let fail = 1
  echo FAIL X10 write-back 0 Y current high
end
if ii_x10_b0 < 0.34
  let fail = 1
  echo FAIL X10 write-back 0 inhibit current low
end
if ii_x10_b0 > 0.46
  let fail = 1
  echo FAIL X10 write-back 0 inhibit current high
end
if m_x00_x11_w1 > -0.9
  let fail = 1
  echo FAIL X11 write 1 left X00 high
end
if m_x01_x11_w1 > -0.9
  let fail = 1
  echo FAIL X11 write 1 left X01 high
end
if m_x10_x11_w1 > -0.9
  let fail = 1
  echo FAIL X11 write 1 left X10 high
end
if m_x11_x11_w1 < 0.9
  let fail = 1
  echo FAIL X11 write 1 did not set X11
end
let pk = smax_x11_w1
if abs(smin_x11_w1) > pk
  let pk = abs(smin_x11_w1)
end
if pk < 15m
  let fail = 1
  echo FAIL X11 write 1 sense below 15 mV
end
if pk > 80m
  let fail = 1
  echo FAIL X11 write 1 sense above 80 mV
end
if ix_x11_w1 < 0.34
  let fail = 1
  echo FAIL X11 write 1 X current low
end
if ix_x11_w1 > 0.46
  let fail = 1
  echo FAIL X11 write 1 X current high
end
if iy_x11_w1 < 0.34
  let fail = 1
  echo FAIL X11 write 1 Y current low
end
if iy_x11_w1 > 0.46
  let fail = 1
  echo FAIL X11 write 1 Y current high
end
if m_x00_x11_r1 > -0.9
  let fail = 1
  echo FAIL X11 read 1 left X00 high
end
if m_x01_x11_r1 > -0.9
  let fail = 1
  echo FAIL X11 read 1 left X01 high
end
if m_x10_x11_r1 > -0.9
  let fail = 1
  echo FAIL X11 read 1 left X10 high
end
if m_x11_x11_r1 > -0.9
  let fail = 1
  echo FAIL X11 read 1 left X11 high
end
let pk = smax_x11_r1
if abs(smin_x11_r1) > pk
  let pk = abs(smin_x11_r1)
end
if pk < 15m
  let fail = 1
  echo FAIL X11 read 1 sense below 15 mV
end
if pk > 80m
  let fail = 1
  echo FAIL X11 read 1 sense above 80 mV
end
if ix_x11_r1 > -0.34
  let fail = 1
  echo FAIL X11 read 1 X current weak
end
if ix_x11_r1 < -0.46
  let fail = 1
  echo FAIL X11 read 1 X current strong
end
if iy_x11_r1 > -0.34
  let fail = 1
  echo FAIL X11 read 1 Y current weak
end
if iy_x11_r1 < -0.46
  let fail = 1
  echo FAIL X11 read 1 Y current strong
end
if m_x00_x11_b1 > -0.9
  let fail = 1
  echo FAIL X11 write-back 1 left X00 high
end
if m_x01_x11_b1 > -0.9
  let fail = 1
  echo FAIL X11 write-back 1 left X01 high
end
if m_x10_x11_b1 > -0.9
  let fail = 1
  echo FAIL X11 write-back 1 left X10 high
end
if m_x11_x11_b1 < 0.9
  let fail = 1
  echo FAIL X11 write-back 1 did not set X11
end
let pk = smax_x11_b1
if abs(smin_x11_b1) > pk
  let pk = abs(smin_x11_b1)
end
if pk < 15m
  let fail = 1
  echo FAIL X11 write-back 1 sense below 15 mV
end
if pk > 80m
  let fail = 1
  echo FAIL X11 write-back 1 sense above 80 mV
end
if ix_x11_b1 < 0.34
  let fail = 1
  echo FAIL X11 write-back 1 X current low
end
if ix_x11_b1 > 0.46
  let fail = 1
  echo FAIL X11 write-back 1 X current high
end
if iy_x11_b1 < 0.34
  let fail = 1
  echo FAIL X11 write-back 1 Y current low
end
if iy_x11_b1 > 0.46
  let fail = 1
  echo FAIL X11 write-back 1 Y current high
end
if m_x00_x11_clr > -0.9
  let fail = 1
  echo FAIL X11 clear left X00 high
end
if m_x01_x11_clr > -0.9
  let fail = 1
  echo FAIL X11 clear left X01 high
end
if m_x10_x11_clr > -0.9
  let fail = 1
  echo FAIL X11 clear left X10 high
end
if m_x11_x11_clr > -0.9
  let fail = 1
  echo FAIL X11 clear left X11 high
end
let pk = smax_x11_clr
if abs(smin_x11_clr) > pk
  let pk = abs(smin_x11_clr)
end
if pk < 15m
  let fail = 1
  echo FAIL X11 clear sense below 15 mV
end
if pk > 80m
  let fail = 1
  echo FAIL X11 clear sense above 80 mV
end
if ix_x11_clr > -0.34
  let fail = 1
  echo FAIL X11 clear X current weak
end
if ix_x11_clr < -0.46
  let fail = 1
  echo FAIL X11 clear X current strong
end
if iy_x11_clr > -0.34
  let fail = 1
  echo FAIL X11 clear Y current weak
end
if iy_x11_clr < -0.46
  let fail = 1
  echo FAIL X11 clear Y current strong
end
if m_x00_x11_w0 > -0.9
  let fail = 1
  echo FAIL X11 write 0 left X00 high
end
if m_x01_x11_w0 > -0.9
  let fail = 1
  echo FAIL X11 write 0 left X01 high
end
if m_x10_x11_w0 > -0.9
  let fail = 1
  echo FAIL X11 write 0 left X10 high
end
if m_x11_x11_w0 > -0.9
  let fail = 1
  echo FAIL X11 write 0 left X11 high
end
let pk = smax_x11_w0
if abs(smin_x11_w0) > pk
  let pk = abs(smin_x11_w0)
end
if pk > 15m
  let fail = 1
  echo FAIL X11 write 0 produced a flip plateau
end
if ix_x11_w0 < 0.34
  let fail = 1
  echo FAIL X11 write 0 X current low
end
if ix_x11_w0 > 0.46
  let fail = 1
  echo FAIL X11 write 0 X current high
end
if iy_x11_w0 < 0.34
  let fail = 1
  echo FAIL X11 write 0 Y current low
end
if iy_x11_w0 > 0.46
  let fail = 1
  echo FAIL X11 write 0 Y current high
end
if ii_x11_w0 < 0.34
  let fail = 1
  echo FAIL X11 write 0 inhibit current low
end
if ii_x11_w0 > 0.46
  let fail = 1
  echo FAIL X11 write 0 inhibit current high
end
if m_x00_x11_r0 > -0.9
  let fail = 1
  echo FAIL X11 read 0 left X00 high
end
if m_x01_x11_r0 > -0.9
  let fail = 1
  echo FAIL X11 read 0 left X01 high
end
if m_x10_x11_r0 > -0.9
  let fail = 1
  echo FAIL X11 read 0 left X10 high
end
if m_x11_x11_r0 > -0.9
  let fail = 1
  echo FAIL X11 read 0 left X11 high
end
let pk = smax_x11_r0
if abs(smin_x11_r0) > pk
  let pk = abs(smin_x11_r0)
end
if pk > 15m
  let fail = 1
  echo FAIL X11 read 0 produced a flip plateau
end
if ix_x11_r0 > -0.34
  let fail = 1
  echo FAIL X11 read 0 X current weak
end
if ix_x11_r0 < -0.46
  let fail = 1
  echo FAIL X11 read 0 X current strong
end
if iy_x11_r0 > -0.34
  let fail = 1
  echo FAIL X11 read 0 Y current weak
end
if iy_x11_r0 < -0.46
  let fail = 1
  echo FAIL X11 read 0 Y current strong
end
if m_x00_x11_b0 > -0.9
  let fail = 1
  echo FAIL X11 write-back 0 left X00 high
end
if m_x01_x11_b0 > -0.9
  let fail = 1
  echo FAIL X11 write-back 0 left X01 high
end
if m_x10_x11_b0 > -0.9
  let fail = 1
  echo FAIL X11 write-back 0 left X10 high
end
if m_x11_x11_b0 > -0.9
  let fail = 1
  echo FAIL X11 write-back 0 left X11 high
end
let pk = smax_x11_b0
if abs(smin_x11_b0) > pk
  let pk = abs(smin_x11_b0)
end
if pk > 15m
  let fail = 1
  echo FAIL X11 write-back 0 produced a flip plateau
end
if ix_x11_b0 < 0.34
  let fail = 1
  echo FAIL X11 write-back 0 X current low
end
if ix_x11_b0 > 0.46
  let fail = 1
  echo FAIL X11 write-back 0 X current high
end
if iy_x11_b0 < 0.34
  let fail = 1
  echo FAIL X11 write-back 0 Y current low
end
if iy_x11_b0 > 0.46
  let fail = 1
  echo FAIL X11 write-back 0 Y current high
end
if ii_x11_b0 < 0.34
  let fail = 1
  echo FAIL X11 write-back 0 inhibit current low
end
if ii_x11_b0 > 0.46
  let fail = 1
  echo FAIL X11 write-back 0 inhibit current high
end

if abs(i_unsel_x) > 0.05
  let fail = 1
  echo FAIL unselected X1 current during X00 read
end
if abs(i_unsel_y) > 0.05
  let fail = 1
  echo FAIL unselected Y1 current during X00 read
end
if abs(i_unsel_x0) > 0.05
  let fail = 1
  echo FAIL unselected X0 current during X01 read
end
if abs(i_g1) > 0.005
  let fail = 1
  echo FAIL group-1 HS current while address stays in group 0
end
meas tran dout_8 FIND v(dout) AT=10.30u
if dout_8 < 1.5
  let fail = 1
  echo FAIL DOUT low after read at 8u
end
meas tran dout_20 FIND v(dout) AT=22.30u
if dout_20 < 1.5
  let fail = 1
  echo FAIL DOUT low after read at 20u
end
meas tran dout_50 FIND v(dout) AT=52.30u
if dout_50 < 1.5
  let fail = 1
  echo FAIL DOUT low after read at 50u
end
meas tran dout_62 FIND v(dout) AT=64.30u
if dout_62 < 1.5
  let fail = 1
  echo FAIL DOUT low after read at 62u
end
meas tran dout_92 FIND v(dout) AT=94.30u
if dout_92 < 1.5
  let fail = 1
  echo FAIL DOUT low after read at 92u
end
meas tran dout_104 FIND v(dout) AT=106.35u
if dout_104 < 1.5
  let fail = 1
  echo FAIL DOUT low after read at 104u
end
meas tran dout_134 FIND v(dout) AT=136.35u
if dout_134 < 1.5
  let fail = 1
  echo FAIL DOUT low after read at 134u
end
meas tran dout_146 FIND v(dout) AT=148.35u
if dout_146 < 1.5
  let fail = 1
  echo FAIL DOUT low after read at 146u
end
meas tran dout_32 FIND v(dout) AT=34.30u
if dout_32 > 0.5
  let fail = 1
  echo FAIL DOUT high after read at 32u
end
meas tran dout_74 FIND v(dout) AT=76.30u
if dout_74 > 0.5
  let fail = 1
  echo FAIL DOUT high after read at 74u
end
meas tran dout_116 FIND v(dout) AT=118.35u
if dout_116 > 0.5
  let fail = 1
  echo FAIL DOUT high after read at 116u
end
meas tran dout_158 FIND v(dout) AT=160.35u
if dout_158 > 0.5
  let fail = 1
  echo FAIL DOUT high after read at 158u
end
meas tran idle_rev FIND v(g_x0w) AT=10.5u
if idle_rev > 0.2
  let fail = 1
  echo FAIL REV gate on during a FWD read
end
* Enables open. The 10 kohm pulls hold DEC_EN low and both banks inactive.
meas tran g_off_x0r FIND v(g_x0r) AT=174u
meas tran g_off_x1r FIND v(g_x1r) AT=174u
meas tran g_off_x0w FIND v(g_x0w) AT=174u
meas tran g_off_x1w FIND v(g_x1w) AT=174u
meas tran g_off_y0r FIND v(g_y0r) AT=174u
meas tran g_off_y1r FIND v(g_y1r) AT=174u
meas tran g_off_y0w FIND v(g_y0w) AT=174u
meas tran g_off_y1w FIND v(g_y1w) AT=174u
meas tran dout_open FIND v(dout) AT=174u
if g_off_x0r > 0.05
  let fail = 1
  echo FAIL X0 FWD gate on with enables open
end
if g_off_x1r > 0.05
  let fail = 1
  echo FAIL X1 FWD gate on with enables open
end
if g_off_x0w > 0.05
  let fail = 1
  echo FAIL X0 REV gate on with enables open
end
if g_off_x1w > 0.05
  let fail = 1
  echo FAIL X1 REV gate on with enables open
end
if g_off_y0r > 0.05
  let fail = 1
  echo FAIL Y0 FWD gate on with enables open
end
if g_off_y1r > 0.05
  let fail = 1
  echo FAIL Y1 FWD gate on with enables open
end
if g_off_y0w > 0.05
  let fail = 1
  echo FAIL Y0 REV gate on with enables open
end
if g_off_y1w > 0.05
  let fail = 1
  echo FAIL Y1 REV gate on with enables open
end
if dout_open > 0.5
  let fail = 1
  echo FAIL DOUT rose with enables open
end
if fail = 0
  echo RESULT PASS
else
  echo RESULT FAIL
end
.endc
.end
